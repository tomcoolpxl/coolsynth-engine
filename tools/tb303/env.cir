* Roland TB-303 envelope generator (the filter's, the "MEG"), from the service notes (First Edition, 1982, p. 5;
* D275), checked against the x0xb0x's schematic (Open Music Labs' redraw): the gate's transistors, the one-shot that
* charges C62, its buffer, the decay through R138 and DECAY, and the accent's switches. The reference for CoolSynth
* 303's envelope.
*
* Rails as ideal sources: 12 V, 5.333 V. Transistors as vco.cir has them; the 2SK30(Y) (Q39) as an N-JFET of Idss
* 2 mA (rank Y: 1.2 to 3 mA); the 1S2473 as the 1N4148; the 4066's switches (IC12, on 12 V) as 200 ohm when on.
*
* The CPU's gate (connector 9, PI2) through R146 and R144 into Q37; Q37's collector pulls Q36's base (R143), whose
* collector is GATE (R145 to ground), and through C54 (0.047 uF) and R148 kicks Q38 on for a moment: the one-shot,
* "MONO MULTI" on page 3. Q38 charges C62 (1 uF) through D37 and R152. Q41 and Q40 follow C62 over Q39, a current
* sink: their emitter is the envelope (ENV MOD's top, and IC12A). C62 falls through R138 (68k) to the DECAY line,
* then DECAY (VR6, 1 M A, wired as a variable resistor) to the diode string D28, D29, D26 (R117 from 5.333 V into
* D26); on an accent IC12B shorts DECAY out (page 5: 200 ms to 2.5 s from 100 % to 10 %; Whittle: 200 ms on an
* accent). On an accent IC12A passes the envelope to the ACCENT knob (VR7, 50k B): its wiper feeds the filter's C13
* through D24 and the VCA through R119.
*
* The ACCENT line: IC13's latch through Q35 (R139 100k from 12 V); here the acc parameter's volts on IC12's controls.
* Loads: ENV MOD (VR5 50k and R61 10k to the filter's VQ9, 3.3 V), the ACCENT knob's wiper into R119 (47k) and C36
* (0.033 uF) toward the VCA's control input (taken as 0.6 V until vca.cir).
*
* Parameters: decay (DECAY's turn, 0..1), acc (12: an accented note, 0: not), accent (ACCENT's turn, 0..1), ton and
* toff (the gate's rise and fall, seconds), taoff (the accent's end: IC13 latches it for the whole step, so by
* default a sixteenth at 120 BPM after ton), tend.
* The 12 V rail: IC16 makes it from the 5.333 V reference times 1 + R178 / R179 (2.2k / 1.8k), 11.85 V, not the 12 V
* drawn (D275); with 5 % resistors a unit may sit anywhere from about 11.4 to 12.3 V. vcc sets it.
.param decay=0 acc=0 accent=0.5 ton=10m toff=72.5m taoff=135m vcc=11.851 tend=0.5
.param ka=3.47
.param tdec={(exp(ka*decay)-1)/(exp(ka)-1)} rdec={max(1Meg*tdec, 1)}
.param racc1={max(50k*accent, 1)} racc3={max(50k*(1-accent), 1)}

.model QEM NPN(IS=39f XTI=3 EG=1.11 VAF=74.03 BF=416.4 NE=1.259 ISE=6.734f IKF=66.78m XTB=1.5 BR=.7371 NC=2
+ ISC=0 IKR=0 RC=1 CJC=3.638p MJC=.3085 VJC=.75 FC=.5 CJE=4.493p MJE=.2593 VJE=.75 TR=239.5n TF=301.2p ITF=.4
+ VTF=4 XTF=2 RB=10)
.model QPM PNP(IS=39f XTI=3 EG=1.11 VAF=18.7 BF=300 NE=1.5 ISE=0 IKF=80m XTB=1.5 BR=4.977 NC=2 ISC=0 IKR=0
+ RC=2.5 CJC=9.728p MJC=.5776 VJC=.75 FC=.5 CJE=8.063p MJE=.3677 VJE=.75 TR=33.42n TF=179.3p ITF=.4 VTF=4 XTF=6
+ RB=10)
.model JFY NJF(VTO=-1.5 BETA=0.89m LAMBDA=2m CGS=8p CGD=3p)
.model DEM D(IS=2.52n N=1.752 RS=0.568 CJO=2p)
.model SWI SW(VT=6 VH=0.5 RON=200 ROFF=1G)

VCC vcc 0 {vcc}
VR vr 0 5.333

* The gate, 0 or 5 V from the CPU.
VG ng 0 PWL(0 0 {ton} 0 {ton+1u} 5 {toff} 5 {toff+1u} 0)
R146 ng nb37 22k
R144 nb37 0 10k
Q37 nc37 nb37 0 QEM

* Q36: GATE.
R147 vcc ne36 22
R142 vcc nb36 10k
C72 vcc nb36 10u
R143 nb36 nc37 10k
Q36 ngate nb36 ne36 QPM
R145 ngate 0 10k

* Q38: the one-shot into C62.
R150 vcc ne38 22
C55 ne38 0 47u
R149 vcc nb38 10k
R148 nb38 n54 10k
C54 n54 nc37 0.047u
Q38 nc38 nb38 ne38 QPM
R151 nc38 0 22k
D37 nc38 n152 DEM
R152 n152 nc62 100
C62 nc62 0 1u

* The buffer: Q41 and Q40 over Q39 (gate and source to ground).
Q41 vcc nc62 ne41 QEM
Q40 vcc ne41 nenv QEM
J39 nenv 0 0 JFY

* The decay: R138 to the DECAY line, DECAY to the diode string; IC12B shorts DECAY on an accent.
VACC nacc 0 PWL(0 0 {ton} 0 {ton+1u} {acc} {taoff} {acc} {taoff+1u} 0)
R138 nc62 ndec 68k
RDEC ndec nn4 {rdec}
S12B ndec nn4 nacc 0 SWI
D28 nn4 nn3 DEM
D29 nn3 nn2 DEM
R117 vr nn2 22k
D26 nn2 0 DEM

* IC12A: the envelope to the ACCENT knob on an accent; its wiper toward the VCA (R119, C36) and the filter (D24).
S12A nenv nacc3 nacc 0 SWI
RACC3 nacc3 naccw {racc3}
RACC1 naccw 0 {racc1}
R119 naccw n36 47k
C36 n36 0 0.033u
R120 n36 n27 22k
VD27 n27 0 0.6

* ENV MOD's load: 50k and R61 to the filter's VQ9.
RLOAD nenv nvq9 60k
VQ9 nvq9 0 3.31

.options method=trap reltol=1e-5 abstol=1e-12 vntol=1e-7
.tran 10u {tend} 0 10u
.end
